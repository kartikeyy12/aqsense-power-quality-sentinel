* AQSENSE - Analog Mains Power Quality Sentinel : final integrated netlist (LTspice 26.1.1)
* Exported via View > SPICE Netlist and tidied for portability (library paths shortened, debug .meas lines removed).
* Needs the models listed in simulation/models/README.md.
* Mains is modelled as V1 with Vpk = 0.074 x V_rms  (Vpk=17.48 -> ~236 V rms).  B_SENSE feeds the frequency
* channel with 0.0286 x mains (0.5 V peak at Vpk=17.48).  Change .param Vpk to sweep the mains voltage and the
* SINE frequency in V1 to sweep mains frequency.
V1 MAINS_A MAINS_B SINE(0 {Vpk} 50)
D1 MAINS_A N007 D
D2 MAINS_B N007 D
D3 0 MAINS_A D
D4 0 MAINS_B D
C1 N007 0 0.001
R1 N007 0 470
X§U1 N007 0 VREG_OUT LM7809 ;§pnba Input)Gnd)Output
R3 N007 VSENSE 22000
R4 VSENSE 0 10000
X§U2 V2 VSENSE VREG_OUT 0 COMP1_OUT LM339 ;§pnba +)-)V+)V-)O/P
X§U3 V4 VSENSE VREG_OUT 0 COMP2_OUT LM339 ;§pnba +)-)V+)V-)O/P
R6 COMP2_OUT VREG_OUT 10000
R2 VREG_OUT 0 1000
R5 COMP1_OUT VREG_OUT 10000
X§U4 V3 VSENSE VREG_OUT 0 COMP3_OUT LM339 ;§pnba +)-)V+)V-)O/P
X§U5 V5 VSENSE VREG_OUT 0 COMP4_OUT LM339 ;§pnba +)-)V+)V-)O/P
R7 COMP3_OUT VREG_OUT 10000
R8 COMP4_OUT VREG_OUT 10000
R9 N005 VREG_OUT 470
R10 N001 VREG_OUT 470
R11 N002 VREG_OUT 470
R12 N003 VREG_OUT 470
D§LED1 N005 COMP1_OUT D
D§LED2 N001 COMP2_OUT D
D§LED3 N002 COMP3_OUT D
D§LED4 N003 COMP4_OUT D
R13 VREG_OUT V_MID 10000
R14 V_MID 0 10000
X§U6 V_MID COMP4_OUT VREG_OUT 0 COMP4_INV LM339 ;§pnba +)-)V+)V-)O/P
D5 COMP4_INV OR_OUT D
D6 COMP1_OUT OR_OUT D
R15 OR_OUT 0 1000
X§U8 0 TIME BUZZER_OUT OR_OUT N006 TIME N004 VREG_OUT NE555 ;§pnba GND)TRIG)OUT)RST)CV)THRS)DIS)Vcc
R16 VREG_OUT N004 1000
R17 N004 TIME 6800
C2 N006 0 0.00000001
R18 BUZZER_OUT 0 100
C3 TIME 0 0.0000001
X§U9 VSENSE N008 VREG_OUT 0 N008 LM324 ;§pnba +)-)V+)V-)Vout
C4 SH_HOLD 0 0.000001
X§U10 SH_HOLD SH_OUT VREG_OUT 0 SH_OUT LM324 ;§pnba +)-)V+)V-)Vout
X§U7 COMP4_INV 0 N008 SH_HOLD AnalogGate ;§pnba +)-)IN)OUT
R19 VREG_OUT COMP4_INV 10000
C5 AC_IN SENSE_IN 0.000001
R20 VBIAS_S N009 10000
R21 SCHMITT_OUT N009 150000
R22 VBIAS_S AC_IN 4700
X§U11 N009 AC_IN VREG_OUT 0 SCHMITT_OUT LM339 ;§pnba +)-)V+)V-)O/P
R23 VREG_OUT SCHMITT_OUT 10000
C6 0 N009 0.0000000001
R24 VREG_OUT VBIAS_S 2200
R25 VBIAS_S 0 2200
C7 VBIAS_S 0 0.00001
X§U12 0 DIFF_TRIG MONO_OUT VREG_OUT N010 MONO_T MONO_T VREG_OUT NE555 ;§pnba GND)TRIG)OUT)RST)CV)THRS)DIS)Vcc
R26 VREG_OUT DIFF_TRIG 10000
D7 DIFF_TRIG VREG_OUT D
C8 SCHMITT_OUT DIFF_TRIG 0.00000001
C9 N010 0 0.00000001
R27 VREG_OUT MONO_T 47000
C10 MONO_T 0 0.0000001
X§U13 NODE_B FREQ_V VREG_OUT 0 FREQ_V LM324 ;§pnba +)-)V+)V-)Vout
R28 NODE_A MONO_OUT 100000
R29 NODE_A NODE_B 100000
C11 NODE_B 0 0.00000033
C12 NODE_A FREQ_V 0.00000068
X§U14 V7 FREQ_V VREG_OUT 0 FREQ_HI LM339 ;§pnba +)-)V+)V-)O/P
X§U15 FREQ_V V8 VREG_OUT 0 FREQ_LO LM339 ;§pnba +)-)V+)V-)O/P
R30 VREG_OUT FREQ_HI 10000
R31 VREG_OUT FREQ_LO 10000
R33 P001 VREG_OUT 470
D9 P001 FREQ_LO D
R32 P002 VREG_OUT 470
D8 P002 FREQ_HI D
R34 VREG_OUT OK_SIG 10000
D10 OK_SIG FREQ_HI D
D11 OK_SIG FREQ_LO D
X§U16 V_MID OK_SIG VREG_OUT 0 FREQ_OK_N LM339 ;§pnba +)-)V+)V-)O/P
R35 VREG_OUT FREQ_OK_N 10000
R36 P003 VREG_OUT 470
D12 P003 FREQ_OK_N D
R37 V5 VREG_OUT 7140
R38 V3 V5 914
R39 V4 V3 1822
R40 V2 V4 914
R41 0 V2 7210
R42 VREG_OUT V7 13252
R43 V7 V8 184
R44 V8 0 4564
B_SENSE SENSE_IN 0 V=0.0286*V(mains_a,mains_b)
.model D D
.lib standard.dio
.param Vpk=17.48
.tran 0 1 0 50u
.include LM324.lib
.include LM7809.lib
.include LM741.lib
.include LM339.lib
.include AnalogGate.lib
.options gmin=1e-9 reltol=0.01
.meas TRAN Vrip_max MAX V(vreg_out)
.meas TRAN Vrip_min MIN V(vreg_out)
.meas TRAN pw TRIG V(mono_out)=4.5 RISE=3 TARG V(mono_out)=4.5 FALL=3
.meas TRAN fv_avg AVG V(freq_v) FROM 0.7 TO 1.0
.meas TRAN vs AVG V(vsense) FROM 0.7 TO 1.0
.meas TRAN bz AVG V(or_out) FROM 0.7 TO 1.0
.lib NE555.sub
.end
